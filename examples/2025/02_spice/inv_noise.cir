Inverter DC Transfer

.include "~/OpenRAM/skywater-pdk/libraries/sky130_fd_pr/latest/models/corners/tt.spice"
.include "~/OpenRAM/skywater-pdk/libraries/sky130_fd_sc_hd/latest/cells/inv/sky130_fd_sc_hd__inv_1.spice"

* the voltage sources:
Vin vin 0 pulse(0 1.8 0p 4n 2n 10n 20n)
Vsin vin A sin(0 0.2 1GHz)
Vdd vdd 0 dc 1.8

Xinv A 0 0 vdd vdd vout sky130_fd_sc_hd__inv_1

Cload vout 0 2fF

.tran 0.1n 70n

.control
    run
    plot A vout
.endc
